* (C) TPS7A49-class LDO from VBAT behind 47 ohm + 10 uF

* 4S battery 14.8 V + motor PWM ripple (100 kHz) + fan (300 kHz), assumed amplitudes
Vbatdc b0 0 14.8
Btri b1 b0 V = 0.105*(2*abs(2*(time*100e3 - floor(time*100e3 + 0.5))) - 1)/2
Bsq b2 b1 V = 0.045*((time*100e3 - floor(time*100e3)) < 0.5 ? 0.5 : -0.5)
Bfan b3 b2 V = 0.05*((time*300e3 - floor(time*300e3)) < 0.37 ? 0.5 : -0.5)
Rsrc b3 vbat 0.1
Cbat vbat 0 1u
Rpre vbat vpre 47
Cpre vpre vpre_c 10u
Rprec vpre_c 0 5m
.ic v(vpre)=14.35 v(vpre_c)=14.35

* la: behavioural LDO (loop as supply3v3/sim3v3.py, TPS7A20 Fig. 5-51 calibration); PSRR added in analyze.py
Blae lae 0 V = 3.3 - v(va)
Blar lar 0 V = 18.8496*v(lae) + v(lai)
Blai 0 lai I = 2.36871e+06*v(lae) + 5e4*(v(lac) - v(lar))
Clai lai 0 1
Rlai lai 0 1e9
Blac lac 0 V = max(0, min(0.15, v(lar)))
Rlal lac lal 100
Clal lal 0 1n
Blao vpre va I = v(lal) * min(1, max(0, (v(vpre) - v(va) - 0.05) / 0.1))
.ic v(lai)=0.01 v(va)=3.3
Cla va va_c 10u
Rla va_c 0 5m
Iana va 0 8m
Rvd va vdda 0.02
Cvd1 vdda vdda_1 1u
Rvd1 vdda_1 0 10m
Cvd2 vdda vdda_2 100n
Rvd2 vdda_2 0 20m
Iadc vdda 0 1m
Vd3 v3d 0 3.3

.options method=gear reltol=1e-4 abstol=1e-9 vntol=1e-7 itl4=200
.control
  set noaskquit
  tran 2e-08 0.007 0.002 5n uic
  linearize v(vdda) v(v3d) v(vbat) v(vpre)
  wrdata C_line.dat v(vdda) v(v3d) v(vbat) v(vpre)
.endc
.end
